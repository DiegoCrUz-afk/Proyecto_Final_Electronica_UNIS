* prueba de la logica: 16 combinaciones E G P F
.include "C:/Users/Diego Cruz/Documents/Proyecto_Final_Electronica_UNIS/3_archivos_tecnicos/modelos.inc"
.include "C:/Users/Diego Cruz/Documents/Proyecto_Final_Electronica_UNIS/3_archivos_tecnicos/sistema.inc"
Vv5 v5 0 5
Ve e_n 0 PWL(0.000000 0.00 0.639999 0.00 0.640000 5.00)
Vg g_n 0 PWL(0.000000 0.00 0.319999 0.00 0.320000 5.00 0.639999 5.00 0.640000 0.00 0.959999 0.00 0.960000 5.00)
Vp p_n 0 PWL(0.000000 0.00 0.159999 0.00 0.160000 5.00 0.319999 5.00 0.320000 0.00 0.479999 0.00 0.480000 5.00 0.639999 5.00 0.640000 0.00 0.799999 0.00 0.800000 5.00 0.959999 5.00 0.960000 0.00 1.119999 0.00 1.120000 5.00)
Vr r_n 0 PWL(0.000000 5.00 0.014999 5.00 0.015000 0.00 0.079999 0.00 0.080000 5.00 0.094999 5.00 0.095000 0.00 0.159999 0.00 0.160000 5.00 0.174999 5.00 0.175000 0.00 0.239999 0.00 0.240000 5.00 0.254999 5.00 0.255000 0.00 0.319999 0.00 0.320000 5.00 0.334999 5.00 0.335000 0.00 0.399999 0.00 0.400000 5.00 0.414999 5.00 0.415000 0.00 0.479999 0.00 0.480000 5.00 0.494999 5.00 0.495000 0.00 0.559999 0.00 0.560000 5.00 0.574999 5.00 0.575000 0.00 0.639999 0.00 0.640000 5.00 0.654999 5.00 0.655000 0.00 0.719999 0.00 0.720000 5.00 0.734999 5.00 0.735000 0.00 0.799999 0.00 0.800000 5.00 0.814999 5.00 0.815000 0.00 0.879999 0.00 0.880000 5.00 0.894999 5.00 0.895000 0.00 0.959999 0.00 0.960000 5.00 0.974999 5.00 0.975000 0.00 1.039999 0.00 1.040000 5.00 1.054999 5.00 1.055000 0.00 1.119999 0.00 1.120000 5.00 1.134999 5.00 1.135000 0.00 1.199999 0.00 1.200000 5.00 1.214999 5.00 1.215000 0.00)
Vfc fc_n 0 PWL(0.000000 0.00 0.099999 0.00 0.100000 5.00 0.104999 5.00 0.105000 0.00 0.259999 0.00 0.260000 5.00 0.264999 5.00 0.265000 0.00 0.419999 0.00 0.420000 5.00 0.424999 5.00 0.425000 0.00 0.579999 0.00 0.580000 5.00 0.584999 5.00 0.585000 0.00 0.739999 0.00 0.740000 5.00 0.744999 5.00 0.745000 0.00 0.899999 0.00 0.900000 5.00 0.904999 5.00 0.905000 0.00 1.059999 0.00 1.060000 5.00 1.064999 5.00 1.065000 0.00 1.219999 0.00 1.220000 5.00 1.224999 5.00 1.225000 0.00)
Re e_n ein 100
Rg g_n gin 100
Rr r_n rin 100
Rp p_n p 100
.model SWF SW(Ron=10 Roff=1G Vt=2.5 Vh=0.1)
Sf setn 0 fc_n 0 SWF
XL v5 ein gin rin p setn m n l f fn LOGICA
.tran 0 1.280 0 20u
.end
