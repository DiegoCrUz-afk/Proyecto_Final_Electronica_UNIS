* Netlist generado SOLO desde el 3D (datos_r2.json) + patas del datasheet. verificar_contra_datasheets.py
.include "C:/Users/Diego Cruz/Documents/Proyecto_Final_Reduccion2/1_LTspice/modelos.inc"
.include "C:/Users/Diego Cruz/Documents/Proyecto_Final_Reduccion2/1_LTspice/sistema.inc"
.include "C:/Users/Diego Cruz/Documents/Proyecto_Final_Reduccion2/1_LTspice/reduccion2.inc"
.model SWB SW(Ron=0.1 Roff=1G Vt=0.5 Vh=0.1)
.param kir=0.55
RSEN_Rled v5 SEN_nled 270
RSEN_R1 v5 b 47000
RSEN_R2 b 0 10000
QSEN_Q2 SEN_c b SEN_e Q2N3904
RSEN_RE SEN_e 0 150
RSEN_Rc v5 SEN_c 680
RSEN_Ra v5 SEN_th1 10000
RSEN_Rb SEN_th2 0 26800
RSEN_Rpu v5 p 10000
RSEN_Rh p SEN_th 220000
RSEN_T1a SEN_th1 SEN_th {10k*(1-kir)}
RSEN_T1b SEN_th SEN_th2 {10k*kir}
DSEN_TCRTled SEN_nled 0 DIR
ISEN_TCRTph v5 b PWL(0 2u 0.9 2u 0.9001 50u 1.6 50u 1.6001 2u)
RLOG_Rpe ein 0 10000
RLOG_Rse ein LOG_ef 10000
CLOG_Cef LOG_ef 0 1e-07
RLOG_Rpg gin 0 10000
RLOG_Rsg gin LOG_gf 10000
CLOG_Cgf LOG_gf 0 1e-07
RLOG_Rpr rin 0 10000
RLOG_Rsr rin LOG_rf 10000
CLOG_Crf LOG_rf 0 1e-07
CLOG_Cpor v5 LOG_por 1e-06
RLOG_Rpor LOG_por 0 47000
DLOG_Dpor LOG_por LOG_rf D1N4148
RLOG_Rsn v5 setn 10000
VENT_J1 v5 0 PWL(0 0 1m 5)
CENT_Cin v5 0 0.001
MPOT_M1 ds m 0 0 IRLZ44N_P
RPOT_Rpd m 0 10000
RPOT_Rs dm ds 15
QPOT_Qp dm POT_bq ds Q2N3904
RPOT_Rb n POT_bq 1000
DPOT_Dfw dm v5 D1N5819
CPOT_Cb v5 0 0.0001
CPOT_C2 v5 0 1e-07
RALA_Rl f ALA_nl 470
DALA_Dl ALA_nl 0 DLED
RLOG_Rlo v5 LOG_lo 680
DLOG_Dlo LOG_lo LOG_pn DLED
XU1 SEN_th SEN_c v5 0 p LM393
XU8_1 LOG_rst setn LOG_reset_n v5 HC_NAND2
XU8_2 setn fn f v5 HC_NAND2
XU8_3 LOG_reset_n f fn v5 HC_NAND2
XU8_4 p p LOG_pn v5 HC_NAND2
XU9_1 LOG_e LOG_g LOG_m1 v5 HC_AND2
XU9_2 LOG_m1 fn m v5 HC_AND2
XU9_3 m LOG_pn n v5 HC_AND2
XU9_4 m p l v5 HC_AND2
XU11_1 LOG_ef LOG_ein_n v5 HC_SCHINV
XU11_2 LOG_ein_n LOG_e v5 HC_SCHINV
XU11_3 LOG_gf LOG_gin_n v5 HC_SCHINV
XU11_4 LOG_gin_n LOG_g v5 HC_SCHINV
XU11_5 LOG_rf LOG_rin_n v5 HC_SCHINV
XU11_6 LOG_rin_n LOG_rst v5 HC_SCHINV
VENT_TBEc cENT_TBE 0 PWL(0 0 0.15 0 0.15001 1)
SENT_TBE v5 ein cENT_TBE 0 SWB
VENT_TBGc cENT_TBG 0 PWL(0 0 0.15 0 0.15001 1 2.2 1 2.20001 0 2.4 0 2.40001 1)
SENT_TBG v5 gin cENT_TBG 0 SWB
VENT_TBRc cENT_TBR 0 PWL(0 0 3.4 0 3.40001 1 3.42 1 3.42001 0)
SENT_TBR v5 rin cENT_TBR 0 SWB
VENT_TBFc cENT_TBF 0 PWL(0 0 2.8 0 2.80001 1 2.82 1 2.82001 0)
SENT_TBF 0 setn cENT_TBF 0 SWB
Lm v5 xm 3m
Rm xm n2 12
Beb n2 dm V=Ke*V(w)
Cw w 0 {J} ic=0
Bw 0 w I=Ke*I(Lm)-Bfr*V(w)-Tl*tanh(V(w))
.param Ke=0.035 J=1e-5 Bfr=7.2e-6 Tl=0.004
.tran 0 4.2 0 100u
.options plotwinsize=0
.meas tran w_t_normal find V(w) at=0.8
.meas tran m_t_normal find V(m) at=0.8
.meas tran n_t_normal find V(n) at=0.8
.meas tran f_t_normal find V(f) at=0.8
.meas tran p_t_normal find V(p) at=0.8
.meas tran lo_t_normal find V(LOG_lo) at=0.8
.meas tran led_t_normal find V(ALA_nl) at=0.8
.meas tran dm_t_normal find V(dm) at=0.8
.meas tran w_t_objeto find V(w) at=1.5
.meas tran m_t_objeto find V(m) at=1.5
.meas tran n_t_objeto find V(n) at=1.5
.meas tran f_t_objeto find V(f) at=1.5
.meas tran p_t_objeto find V(p) at=1.5
.meas tran lo_t_objeto find V(LOG_lo) at=1.5
.meas tran led_t_objeto find V(ALA_nl) at=1.5
.meas tran dm_t_objeto find V(dm) at=1.5
.meas tran w_t_normal2 find V(w) at=2.1
.meas tran m_t_normal2 find V(m) at=2.1
.meas tran n_t_normal2 find V(n) at=2.1
.meas tran f_t_normal2 find V(f) at=2.1
.meas tran p_t_normal2 find V(p) at=2.1
.meas tran lo_t_normal2 find V(LOG_lo) at=2.1
.meas tran led_t_normal2 find V(ALA_nl) at=2.1
.meas tran dm_t_normal2 find V(dm) at=2.1
.meas tran w_t_cubierta find V(w) at=2.38
.meas tran m_t_cubierta find V(m) at=2.38
.meas tran n_t_cubierta find V(n) at=2.38
.meas tran f_t_cubierta find V(f) at=2.38
.meas tran p_t_cubierta find V(p) at=2.38
.meas tran lo_t_cubierta find V(LOG_lo) at=2.38
.meas tran led_t_cubierta find V(ALA_nl) at=2.38
.meas tran dm_t_cubierta find V(dm) at=2.38
.meas tran w_t_falla find V(w) at=3.1
.meas tran m_t_falla find V(m) at=3.1
.meas tran n_t_falla find V(n) at=3.1
.meas tran f_t_falla find V(f) at=3.1
.meas tran p_t_falla find V(p) at=3.1
.meas tran lo_t_falla find V(LOG_lo) at=3.1
.meas tran led_t_falla find V(ALA_nl) at=3.1
.meas tran dm_t_falla find V(dm) at=3.1
.meas tran w_t_reset find V(w) at=4
.meas tran m_t_reset find V(m) at=4
.meas tran n_t_reset find V(n) at=4
.meas tran f_t_reset find V(f) at=4
.meas tran p_t_reset find V(p) at=4
.meas tran lo_t_reset find V(LOG_lo) at=4
.meas tran led_t_reset find V(ALA_nl) at=4
.meas tran dm_t_reset find V(dm) at=4
.save V(w) V(m) V(n) V(f) V(p) V(LOG_lo) V(ALA_nl) V(dm)
.end
